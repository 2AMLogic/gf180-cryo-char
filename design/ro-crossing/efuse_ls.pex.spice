* extracted by klt extract --deck gf180mcu
* parasitic model (--parasitics):
* - capacitance: net-to-ground for every net's own (non-coupled) area/perimeter, plus net-to-net for the vertical-overlap coupling `coupling` describes below -- a coupled net pair gets a direct capacitor between their two hub nodes, not just capacitors to the deck's ground/substrate net
* - coupling: vertical overlap (crossover) unconditionally -- where one net's conductor on an adjacent metal level sits directly over another *distinct* net's conductor, that overlap area is charged between the two nets instead of to ground (issue #760) -- plus lateral (same-layer, sidewall) coupling, but only for a net pair naming one of the caller's declared `--critical-net` nets (issue #976): facing-edge length within that layer's own minimum-spacing lookback is charged between the two nets, *additively* (not deducted from either net's substrate fringe term, unlike the vertical case -- a known simplification). Any same-layer pair with neither side named `--critical-net`, and fringe shielding in general, are still not modelled
* - resistance: single lumped series resistance per net, distributed as a star across that net's device terminals (issue #592) -- not a per-segment, distributed RC ladder, *unless* `--distributed-rc` names this net via `--critical-net` (issue #977, Epic #709 Phase 2b): then the net's terminals are ordered along their approximate physical spread and its total R/C is broken into a chain of per-segment resistors (segment length proportional to inter-terminal distance) with a ground capacitor at each terminal node (proportional to its adjacent segment length/2), instead of one star hub -- still an approximation (terminal position is a device-placement proxy, not true per-segment routing geometry), but a strictly finer-grained one than the single-hub star
* - frequency: quasi-static -- one frequency-independent R and C per net; no skin effect, no distributed transmission-line behavior
* - substrate tie: 1e+12 ohm to ground -- the substrate is capacitively floating in transient analysis (DC reference only); see --substrate-tie-ohms
.GLOBAL vsubs

* cell efuse_ls
* pin in
* pin out
* pin vdd33
* pin vprog
* pin vss
.SUBCKT efuse_ls in out vdd33 vprog vss
* device instance $1 r0 *1 1.87,1.73 nfet
X$1 inb__t0 in__t0 vss__t0 vss__t3 nfet_03v3 L=0.28U W=1U AS=0.5P AD=0.5P PS=3U
+ PD=3U
* device instance $2 r0 *1 1.87,14.23 pfet
X$2 inb__t1 in__t1 vdd33__t0 vdd33__t1 pfet_03v3 L=0.28U W=2U AS=1P AD=1P PS=5U
+ PD=5U
* device instance $3 r0 *1 8.32,3.23 nfet
X$3 x1__t0 in__t2 vss__t1 vss__t4 nfet_06v0 L=0.7U W=4U AS=2P AD=2P PS=9U PD=9U
* device instance $4 r0 *1 14.98,3.23 nfet
X$4 out__t2 inb__t2 vss__t2 vss__t5 nfet_06v0 L=0.7U W=4U AS=2P AD=2P PS=9U
+ PD=9U
* device instance $5 r0 *1 8.335,13.73 pfet
X$5 x1__t1 out__t0 vprog__t1 vprog__t0 pfet_06v0 L=0.55U W=1U AS=0.5P AD=0.5P
+ PS=3U PD=3U
* device instance $6 r0 *1 14.995,13.73 pfet
X$6 out__t1 x1__t2 vprog__t2 vprog__t3 pfet_06v0 L=0.55U W=1U AS=0.5P AD=0.5P
+ PS=3U PD=3U
* device instance in_t0 r0 *1 0,0
Rin_t0 in__t0 in 31.5387453269
* device instance in_t1 r0 *1 0,0
Rin_t1 in__t1 in 49.8606807744
* device instance in_t2 r0 *1 0,0
Rin_t2 in__t2 in 32.7791738987
* device instance in r0 *1 0,0
Cin in vsubs 2.90683e-15
* device instance inb_t0 r0 *1 0,0
Rinb_t0 inb__t0 inb 14.3277469828
* device instance inb_t1 r0 *1 0,0
Rinb_t1 inb__t1 inb 20.1018199603
* device instance inb_t2 r0 *1 0,0
Rinb_t2 inb__t2 inb 20.8327330569
* device instance inb r0 *1 0,0
Cinb inb vsubs 3.284732e-15
* device instance out_t0 r0 *1 0,0
Rout_t0 out__t0 out 16.2338008782
* device instance out_t1 r0 *1 0,0
Rout_t1 out__t1 out 11.9169785994
* device instance out_t2 r0 *1 0,0
Rout_t2 out__t2 out 21.0923205225
* device instance out r0 *1 0,0
Cout out vsubs 3.278494e-15
* device instance vdd33_t0 r0 *1 0,0
Rvdd33_t0 vdd33__t0 vdd33 1.60815
* device instance vdd33_t1 r0 *1 0,0
Rvdd33_t1 vdd33__t1 vdd33 1.60815
* device instance vdd33 r0 *1 0,0
Cvdd33 vdd33 vsubs 1.790029e-15
* device instance vprog_t0 r0 *1 0,0
Rvprog_t0 vprog__t0 vprog 1.84555
* device instance vprog_t1 r0 *1 0,0
Rvprog_t1 vprog__t1 vprog 1.84555
* device instance vprog_t2 r0 *1 0,0
Rvprog_t2 vprog__t2 vprog 1.84555
* device instance vprog_t3 r0 *1 0,0
Rvprog_t3 vprog__t3 vprog 1.84555
* device instance vprog r0 *1 0,0
Cvprog vprog vsubs 3.480836e-15
* device instance vss_t0 r0 *1 0,0
Rvss_t0 vss__t0 vss 3.27890974966
* device instance vss_t1 r0 *1 0,0
Rvss_t1 vss__t1 vss 0.250967707114
* device instance vss_t2 r0 *1 0,0
Rvss_t2 vss__t2 vss 3.28522254323
* device instance vss_t3 r0 *1 0,0
Rvss_t3 vss__t3 vss 3.27890974966
* device instance vss_t4 r0 *1 0,0
Rvss_t4 vss__t4 vss 0.250967707114
* device instance vss_t5 r0 *1 0,0
Rvss_t5 vss__t5 vss 3.28522254323
* device instance vss r0 *1 0,0
Cvss vss vsubs 7.219907e-15
* device instance x1_t0 r0 *1 0,0
Rx1_t0 x1__t0 x1 20.3403554379
* device instance x1_t1 r0 *1 0,0
Rx1_t1 x1__t1 x1 11.4678374268
* device instance x1_t2 r0 *1 0,0
Rx1_t2 x1__t2 x1 15.6639071353
* device instance x1 r0 *1 0,0
Cx1 x1 vsubs 2.729498e-15
* device instance cc_in_inb r0 *1 0,0
Ccc_in_inb in inb 1.0412e-17
* device instance cc_inb_out r0 *1 0,0
Ccc_inb_out inb out 7.437e-18
* device instance cc_inb_vdd33 r0 *1 0,0
Ccc_inb_vdd33 inb vdd33 1.0412e-17
* device instance cc_inb_vss r0 *1 0,0
Ccc_inb_vss inb vss 1.0412e-17
* device instance cc_inb_x1 r0 *1 0,0
Ccc_inb_x1 inb x1 7.437e-18
* device instance cc_out_vss r0 *1 0,0
Ccc_out_vss out vss 3.6939e-17
* device instance cc_vprog_x1 r0 *1 0,0
Ccc_vprog_x1 vprog x1 1.785e-17
* device instance cc_vss_x1 r0 *1 0,0
Ccc_vss_x1 vss x1 1.0412e-17
* device instance vsubs_dctie r0 *1 0,0
Rvsubs_dctie vsubs 0 1e+12
.ENDS efuse_ls
